// Simple Level-1 MOSFET model for testing analytical Jacobians
// Based on Shichman-Hodges model with minimum gds for numerical stability

`include "discipline.h"

module mosfet_level1(d, g, s, b);
    inout d, g, s, b;
    electrical d, g, s, b;

    // Model parameters
    parameter real VTH0 = 0.4;      // Threshold voltage [V]
    parameter real KP = 200e-6;     // Transconductance parameter [A/V^2]
    parameter real LAMBDA = 0.01;   // Channel length modulation [1/V]
    parameter real W = 1e-6;        // Width [m]
    parameter real L = 0.2e-6;      // Length [m]
    parameter integer PMOS = 0;     // 0=NMOS, 1=PMOS
    parameter real GDSMIN = 1e-9;   // Minimum output conductance [S]

    real Vgs, Vds, Vbs;
    real Vov, Ids, beta;
    real sign;

    analog begin
        // Handle PMOS by flipping voltages
        if (PMOS == 1) begin
            sign = -1.0;
            Vgs = V(s) - V(g);
            Vds = V(s) - V(d);
            Vbs = V(s) - V(b);
        end else begin
            sign = 1.0;
            Vgs = V(g) - V(s);
            Vds = V(d) - V(s);
            Vbs = V(b) - V(s);
        end

        beta = KP * W / L;
        Vov = Vgs - VTH0;

        if (Vov <= 0) begin
            // Cutoff - use minimum conductance for numerical stability
            Ids = GDSMIN * Vds;
        end else if (Vds < Vov) begin
            // Linear (triode) region
            Ids = beta * (Vov * Vds - 0.5 * Vds * Vds) * (1 + LAMBDA * Vds);
        end else begin
            // Saturation region
            Ids = 0.5 * beta * Vov * Vov * (1 + LAMBDA * Vds);
        end

        // Add minimum gds leakage in all regions for numerical stability
        Ids = Ids + GDSMIN * Vds;

        // Apply sign for PMOS
        Ids = sign * Ids;

        // Current flows from drain to source
        I(d, s) <+ Ids;
    end
endmodule
